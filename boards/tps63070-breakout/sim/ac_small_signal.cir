* Secondary `.ac` pass (#79): DC bias + AC on VIN; `.meas` at **10 kHz** and **100 kHz** on `vo_meas` (stub magnitude often ~0 — regression anchors).
* VCVS taps `/vout_+3.3v` → `vo_meas` so `.meas` avoids special characters in node names.
* Run via `sim.yml` `secondary_passes` → second ngspice invocation (`scripts/sim/run_sim.py`).
.include "../../../libs/spice/tps63070/TPS63070_TRANS.LIB"
.include "kicad_export.cir"
.include "extracted_hotloop_fragment.cir"
.include "manual_parasitics.cir"
VVIN VIN_RAW 0 DC 10 AC 1
II_LOAD VOUT_LOAD_END GND DC 0.5
Ecopy vo_meas GND /vout_+3.3v GND 1
.ac dec 15 100 1meg
.meas ac vout_ac_vm FIND V(vo_meas) AT=10000
.meas ac vout_ac_vm_100k FIND V(vo_meas) AT=100000
.end
