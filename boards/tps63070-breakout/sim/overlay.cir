* Board overlay — included after main kicad_export by assemble.py (issue #45).
* Slice 4: TI TPS63070 subckt in libs/spice via sim.yml .include; KiCad Sim.Pins map on U1.
VVIN /VIN_2v_to_16v 0 DC 10
.op
.end
