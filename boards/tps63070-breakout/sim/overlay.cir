* Board overlay — included after main kicad_export by assemble.py (issue #45).
* Stage C layout fragments (#74): `.include` before manual overrides/refinements.
.include "extracted_hotloop_fragment.cir"
.include "manual_parasitics.cir"
.include "transient_stress_body.cir"
.include "overlay_measures.cir"
