* Board overlay — included after main kicad_export by assemble.py.
.include "transient_battery_body.cir"
.include "battery_measures.cir"
